// python3 -m pip install peakrdl
// python3 -m peakrdl html mat_mult.rdl -o html/
// python3 -m peakrdl uvm mat_mult.rdl -o mat_mult_uvm_pkg.sv

addrmap mat_mult {

  default accesswidth = 32;
  default regwidth = 32;
  
  name = "Matrix multiplier";
  desc = "Module to convolve a matrix (max 2^16x2^16) with a square kernel matrix (max 5x5).";
  
  reg {
    name = "Status register";
    desc = "Status of the module to be read";
  
    default sw = r;
    default hw = rw;
    
    field {
      desc = "The current error code.\\n0x0 - no error\\n0x1 - size error\\n0x2 - load order error";
    } error[5:2] = 0;
    
    field {
      desc = "Whether the module is able to compute a result";
    } ready = 0;
    
    field {
      desc = "Whether the module is currently computing a result";
    } multiplying = 0;
  } status_reg;
  
};
